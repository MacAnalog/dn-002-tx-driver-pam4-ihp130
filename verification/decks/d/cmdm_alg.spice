* TB[pam4] .op/ac S21+S11 sweep drive=msb (ngspice-45)
Vcc vcc 0 DC 4
Vcasc vcasc 0 DC 3.31
Vcmb vcmb 0 DC 1.9
Vblsb blsb 0 DC 15.93
Vbmsb bmsb 0 DC 15.93
XDUT lsbp lsbn msbp msbn outp outn vcc vcasc vcmb blsb bmsb pam4drv_pam4
Rlp outp vcc 50
Rln outn vcc 50
Vslsbp slsbp 0 DC 1.9
Vslsbn slsbn 0 DC 1.9
Rslsbp slsbp lsbp 50
Rslsbn slsbn lsbn 50
Vsmsbp smsbp 0 DC 1.9 AC 0.5
Vsmsbn smsbn 0 DC 1.9 AC 0.5
Rsmsbp smsbp msbp 50
Rsmsbn smsbn msbn 50
* post-layout adapter: pam4drv_pam4_lay -> pam4drv_pam4 schematic ports
.subckt pam4drv_pam4 lsbp lsbn msbp msbn outp outn vcc vcasc vcmb blsb bmsb
Xlay sub msbn lsbp vcmb lsbn msbp tmsb0 tmsb1 tlsb0 vcasc outp outn vcc pam4drv_pam4_lay
Gtlsb0 tlsb0 0 blsb 0 1m
Gtmsb0 tmsb0 0 bmsb 0 1m
Gtmsb1 tmsb1 0 bmsb 0 1m
Vsub sub 0 DC 0
.ends pam4drv_pam4
.include "../../../report/layout/d/dut_pam4_post.spice"
.lib "cornerRES.lib" res_typ
.lib "cornerCAP.lib" cap_typ

.lib "cornerHBT.lib" hbt_typ
.options gmin=1e-12 reltol=1e-3
.control
op
print v(outp) v(outn) i(Vcc)
ac dec 100 1e+08 1e+11
let vodiff = v(outp)-v(outn)
let vidiff = v(msbp)-v(msbn)
let s21db = db(2*vodiff)
let zin = vidiff*100/(1-vidiff)
let s11db = db((zin-100)/(zin+100))
let gpdb = db(2*v(outp))
let gndb = db(2*v(outn))
let php = ph(v(outp))*180/pi
let phn = ph(v(outn))*180/pi
let cmdb = db(mag(v(outp)+v(outn))+1e-15)
let ddb = db(mag(v(outp)-v(outn))+1e-15)
wrdata cmdm_alg.csv gpdb gndb php phn cmdb ddb
.endc
.GLOBAL GND
.end
