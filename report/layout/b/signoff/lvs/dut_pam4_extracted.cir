* Extracted by KLayout with SG13G2 LVS runset on : 01/09/2026 00:02

.SUBCKT pam4drv_pam4_lay sub lsbp vcmb lsbn msbp msbn tmsb0 tlsb0 tmsb1 vcasc
+ outp outn vcc
Q$1 outp vcasc \$53 sub npn13G2 AE=0.063p PE=1.94u AB=19.2965p PB=19.32u
+ AC=19.283334p PC=19.31u NE=3 m=3
Q$4 outn vcasc \$52 sub npn13G2 AE=0.063p PE=1.94u AB=19.2965p PB=19.32u
+ AC=19.283334p PC=19.31u NE=3 m=3
Q$7 outp vcasc \$51 sub npn13G2 AE=0.063p PE=1.94u AB=19.2965p PB=19.32u
+ AC=19.283334p PC=19.31u NE=3 m=3
Q$10 outn vcasc \$50 sub npn13G2 AE=0.063p PE=1.94u AB=19.2965p PB=19.32u
+ AC=19.283334p PC=19.31u NE=3 m=3
Q$13 outn vcasc \$54 sub npn13G2 AE=0.063p PE=1.94u AB=19.2965p PB=19.32u
+ AC=19.283334p PC=19.31u NE=3 m=3
Q$16 outp vcasc \$49 sub npn13G2 AE=0.063p PE=1.94u AB=19.2965p PB=19.32u
+ AC=19.283334p PC=19.31u NE=3 m=3
Q$19 \$54 msbn \$15 sub npn13G2 AE=0.063p PE=1.94u AB=19.2965p PB=19.32u
+ AC=19.283334p PC=19.31u NE=3 m=3
Q$22 \$50 msbn \$9 sub npn13G2 AE=0.063p PE=1.94u AB=19.2965p PB=19.32u
+ AC=19.283334p PC=19.31u NE=3 m=3
Q$25 \$53 msbp \$14 sub npn13G2 AE=0.063p PE=1.94u AB=19.2965p PB=19.32u
+ AC=19.283334p PC=19.31u NE=3 m=3
Q$28 \$49 msbp \$8 sub npn13G2 AE=0.063p PE=1.94u AB=19.2965p PB=19.32u
+ AC=19.283334p PC=19.31u NE=3 m=3
Q$31 \$51 lsbp \$11 sub npn13G2 AE=0.063p PE=1.94u AB=19.2965p PB=19.32u
+ AC=19.283334p PC=19.31u NE=3 m=3
Q$34 \$52 lsbn \$12 sub npn13G2 AE=0.063p PE=1.94u AB=19.2965p PB=19.32u
+ AC=19.283334p PC=19.31u NE=3 m=3
R$37 vcmb lsbp rsil w=0.5u l=2.29u ps=0 b=0 m=1
R$38 vcmb lsbn rsil w=0.5u l=2.29u ps=0 b=0 m=1
R$39 vcmb msbp rsil w=0.5u l=2.29u ps=0 b=0 m=1
R$40 vcmb msbn rsil w=0.5u l=2.29u ps=0 b=0 m=1
R$41 tmsb0 \$8 rsil w=5u l=0.5u ps=0 b=0 m=1
R$42 tmsb0 \$9 rsil w=5u l=0.5u ps=0 b=0 m=1
R$43 tlsb0 \$11 rsil w=5u l=0.5u ps=0 b=0 m=1
R$44 tlsb0 \$12 rsil w=5u l=0.5u ps=0 b=0 m=1
R$45 tmsb1 \$14 rsil w=5u l=0.5u ps=0 b=0 m=1
R$46 tmsb1 \$15 rsil w=5u l=0.5u ps=0 b=0 m=1
R$47 outp vcc rsil w=1.4u l=8.71u ps=0 b=0 m=1
R$48 outn vcc rsil w=1.4u l=8.71u ps=0 b=0 m=1
C$49 \$12 \$11 cap_cmim w=3.59u l=3.59u A=12.8881p P=14.36u m=1
C$50 \$15 \$14 cap_cmim w=3.59u l=3.59u A=12.8881p P=14.36u m=1
C$51 \$9 \$8 cap_cmim w=3.59u l=3.59u A=12.8881p P=14.36u m=1
.ENDS pam4drv_pam4_lay
