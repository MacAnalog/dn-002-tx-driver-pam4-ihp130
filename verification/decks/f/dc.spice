* TB[pam4] .dc transfer sweep drive=both other=0mV
Vcc vcc 0 DC 4
Vcasc vcasc 0 DC 3.3427
Vcmb vcmb 0 DC 1.9
Vblsb blsb 0 DC 13.9958
Vbmsb bmsb 0 DC 13.9958
XDUT lsbp lsbn msbp msbn outp outn vcc vcasc vcmb blsb bmsb pam4drv_pam4
Rlp outp vcc 50
Rln outn vcc 50
Vd d 0 DC 0
Bslsbp slsbp 0 V = 1.9 + 0.5*v(d)
Bslsbn slsbn 0 V = 1.9 - 0.5*v(d)
Rslsbp slsbp lsbp 50
Rslsbn slsbn lsbn 50
Bsmsbp smsbp 0 V = 1.9 + 0.5*v(d)
Bsmsbn smsbn 0 V = 1.9 - 0.5*v(d)
Rsmsbp smsbp msbp 50
Rsmsbn smsbn msbn 50
* post-layout adapter: pam4drv_pam4_lay -> pam4drv_pam4 schematic ports
.subckt pam4drv_pam4 lsbp lsbn msbp msbn outp outn vcc vcasc vcmb blsb bmsb
Xlay sub msbn lsbp vcmb lsbn msbp tmsb0 tmsb1 tlsb0 vcasc outp outn vcc pam4drv_pam4_lay
Gtlsb0 tlsb0 0 blsb 0 1m
Gtmsb0 tmsb0 0 bmsb 0 1m
Gtmsb1 tmsb1 0 bmsb 0 1m
Vsub sub 0 DC 0
.ends pam4drv_pam4
.include "../../../report/layout/f/dut_pam4_post.spice"
.lib "cornerRES.lib" res_typ
.lib "cornerCAP.lib" cap_typ

.lib "cornerHBT.lib" hbt_typ
.options gmin=1e-12 reltol=1e-3
.control
dc Vd -0.9 0.9 0.015
wrdata dc.csv v(outp)-v(outn) i(Vcc)
.endc
.GLOBAL GND
.end
