.include /home/noorizad/spicexplorer-workspace/external/pam4-wt/codesign-r4/layout/em/target_r4/em_outnet.sub
* LVS reference for pam4drv_pam4_lay (generated by gen_layout.py — matches the GDS exactly)
.subckt pam4drv_pam4_lay lsbp lsbn msbp msbn outp outn vcc vcasc vcmb tmsb0 tlsb0 tmsb1 sub
XQ1M0 c1M0 msbp e1M0 sub npn13G2 Nx=3
XQ2M0 c2M0 msbn e2M0 sub npn13G2 Nx=3
XQ3M0 outp_tM0 vcasc c1M0 sub npn13G2 Nx=3
XQ4M0 outn_tM0 vcasc c2M0 sub npn13G2 Nx=3
XQ1M1 c1M1 msbp e1M1 sub npn13G2 Nx=3
XQ2M1 c2M1 msbn e2M1 sub npn13G2 Nx=3
XQ3M1 outp_tM1 vcasc c1M1 sub npn13G2 Nx=3
XQ4M1 outn_tM1 vcasc c2M1 sub npn13G2 Nx=3
XQ1L0 c1L0 lsbp e1L0 sub npn13G2 Nx=3
XQ2L0 c2L0 lsbn e2L0 sub npn13G2 Nx=3
XQ3L0 outp_tL0 vcasc c1L0 sub npn13G2 Nx=3
XQ4L0 outn_tL0 vcasc c2L0 sub npn13G2 Nx=3
XRE1M0 e1M0 tmsb0 sub rsil w=5.56u l=1.29u m=1
XRE2M0 e2M0 tmsb0 sub rsil w=5.56u l=1.29u m=1
XRE1M1 e1M1 tmsb1 sub rsil w=5.56u l=1.29u m=1
XRE2M1 e2M1 tmsb1 sub rsil w=5.56u l=1.29u m=1
XRE1L0 e1L0 tlsb0 sub rsil w=5.56u l=1.29u m=1
XRE2L0 e2L0 tlsb0 sub rsil w=5.56u l=1.29u m=1
XRblsbp lsbp vcmb sub rsil w=0.64u l=3.1u m=1
XRblsbn lsbn vcmb sub rsil w=0.64u l=3.1u m=1
XRbmsbp msbp vcmb sub rsil w=0.64u l=3.1u m=1
XRbmsbn msbn vcmb sub rsil w=0.64u l=3.1u m=1
XRcp outp_trc vcc_trc0 sub rsil w=1.52u l=10.02u m=1
XRcn outn_trc vcc_trc1 sub rsil w=1.52u l=10.02u m=1
XCdegM0 e2M0 e1M0 cap_cmim w=3.33u l=3.33u
XCdegM1 e2M1 e1M1 cap_cmim w=3.33u l=3.33u
XCdegL0 e2L0 e1L0 cap_cmim w=3.33u l=3.33u
XEM outp sub outn sub vcc sub outp_tM0 sub outp_tM1 sub outp_tL0 sub outp_trc sub outn_tM0 sub outn_tM1 sub outn_tL0 sub outn_trc sub vcc_trc0 sub vcc_trc1 sub em_outnet
.ends
