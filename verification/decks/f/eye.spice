* TB[pam4] 48 GBaud PAM-4 eye
Vcc vcc 0 PWL(0 0 8n 4)
Vcasc vcasc 0 PWL(0 0 8n 3.3427)
Vcmb vcmb 0 PWL(0 0 8n 1.9)
Vblsb blsb 0 PWL(0 0 8n 13.9958)
Vbmsb bmsb 0 PWL(0 0 8n 13.9958)
XDUT lsbp lsbn msbp msbn outp outn vcc vcasc vcmb blsb bmsb pam4drv_pam4
Rlp outp vcc 50
Rln outn vcc 50
Vsmsbp smsbp 0 PWL(0 2 10n 2 10.004n 2 10.0208n 2 10.0248n 1.8 10.0417n 1.8 10.0457n 2 10.0625n 2 10.0665n 1.8 10.0833n 1.8 10.0873n 1.8 10.1042n 1.8 10.1082n 1.8 10.125n 1.8 10.129n 2 10.1458n 2 10.1498n 1.8 10.1667n 1.8 10.1707n 1.8 10.1875n 1.8 10.1915n 1.8 10.2083n 1.8 10.2123n 1.8 10.2292n 1.8 10.2332n 2 10.25n 2 10.254n 2 10.2708n 2 10.2748n 1.8 10.2917n 1.8 10.2957n 1.8 10.3125n 1.8 10.3165n 1.8 10.3333n 1.8 10.3373n 2 10.3542n 2 10.3582n 1.8 10.375n 1.8 10.379n 1.8 10.3958n 1.8 10.3998n 1.8 10.4167n 1.8 10.4207n 1.8 10.4375n 1.8 10.4415n 2 10.4583n 2 10.4623n 1.8 10.4792n 1.8 10.4832n 1.8 10.5n 1.8 10.504n 1.8 10.5208n 1.8 10.5248n 1.8 10.5417n 1.8 10.5457n 2 10.5625n 2 10.5665n 2 10.5833n 2 10.5873n 1.8 10.6042n 1.8 10.6082n 1.8 10.625n 1.8 10.629n 2 10.6458n 2 10.6498n 1.8 10.6667n 1.8 10.6707n 1.8 10.6875n 1.8 10.6915n 1.8 10.7083n 1.8 10.7123n 2 10.7292n 2 10.7332n 1.8 10.75n 1.8 10.754n 1.8 10.7708n 1.8 10.7748n 1.8 10.7917n 1.8 10.7957n 1.8 10.8125n 1.8 10.8165n 2 10.8333n 2 10.8373n 2 10.8542n 2 10.8582n 2 10.875n 2 10.879n 2 10.8958n 2 10.8998n 2 10.9167n 2 10.9207n 2 10.9375n 2 10.9415n 2 10.9583n 2 10.9623n 1.8 10.9792n 1.8 10.9832n 1.8 11n 1.8 11.004n 1.8 11.0208n 1.8 11.0248n 1.8 11.0417n 1.8 11.0457n 2 11.0625n 2 11.0665n 2 11.0833n 2 11.0873n 2 11.1042n 2 11.1082n 2 11.125n 2 11.129n 2 11.1458n 2 11.1498n 1.8 11.1667n 1.8 11.1707n 1.8 11.1875n 1.8 11.1915n 2 11.2083n 2 11.2123n 1.8 11.2292n 1.8 11.2332n 2 11.25n 2 11.254n 1.8 11.2708n 1.8 11.2748n 2 11.2917n 2 11.2957n 2 11.3125n 2 11.3165n 1.8 11.3333n 1.8 11.3373n 1.8 11.3542n 1.8 11.3582n 2 11.375n 2 11.379n 2 11.3958n 2 11.3998n 2 11.4167n 2 11.4207n 2 11.4375n 2 11.4415n 2 11.4583n 2 11.4623n 1.8 11.4792n 1.8 11.4832n 1.8 11.5n 1.8 11.504n 2 11.5208n 2 11.5248n 2 11.5417n 2 11.5457n 1.8 11.5625n 1.8 11.5665n 1.8 11.5833n 1.8 11.5873n 2 11.6042n 2 11.6082n 2 11.625n 2 11.629n 2 11.6458n 2 11.6498n 2 11.6667n 2 11.6707n 2 11.6875n 2 11.6915n 1.8 11.7083n 1.8 11.7123n 2 11.7292n 2 11.7332n 2 11.75n 2 11.754n 1.8 11.7708n 1.8 11.7748n 1.8 11.7917n 1.8 11.7957n 2 11.8125n 2 11.8165n 1.8 11.8333n 1.8 11.8373n 1.8 11.8542n 1.8 11.8582n 2 11.875n 2 11.879n 1.8 11.8958n 1.8 11.8998n 1.8 11.9167n 1.8 11.9207n 2 11.9375n 2 11.9415n 2 11.9583n 2 11.9623n 2 11.9792n 2 11.9832n 1.8 12n 1.8 12.004n 1.8 12.0208n 1.8 12.0248n 2 12.0417n 2 12.0457n 2 12.0625n 2 12.0665n 2 12.0833n 2 12.0873n 1.8 12.1042n 1.8 12.1082n 2 12.125n 2 12.129n 2 12.1458n 2 12.1498n 2 12.1667n 2 12.1707n 2 12.1875n 2 12.1915n 2 12.2083n 2 12.2123n 1.8 12.2292n 1.8 12.2332n 1.8 12.25n 1.8 12.254n 1.8 12.2708n 1.8 12.2748n 1.8 12.2917n 1.8 12.2957n 1.8 12.3125n 1.8 12.3165n 1.8 12.3333n 1.8 12.3373n 1.8 12.3542n 1.8 12.3582n 1.8 12.375n 1.8 12.379n 2 12.3958n 2 12.3998n 1.8 12.4167n 1.8 12.4207n 2 12.4375n 2 12.4415n 2 12.4583n 2 12.4623n 1.8 12.4792n 1.8 12.4832n 1.8 12.5n 1.8 12.504n 2 12.5208n 2 12.5248n 2 12.5417n 2 12.5457n 2 12.5625n 2 12.5665n 1.8 12.5833n 1.8 12.5873n 1.8 12.6042n 1.8 12.6082n 2 12.625n 2 12.629n 2 12.6458n 2 12.6498n 2 12.6667n 2 12.6707n 2 12.6875n 2 12.6915n 2 12.7083n 2 12.7123n 1.8 12.7292n 1.8 12.7332n 2 12.75n 2 12.754n 2 12.7708n 2 12.7748n 1.8 12.7917n 1.8 12.7957n 1.8 12.8125n 1.8 12.8165n 1.8 12.8333n 1.8 12.8373n 1.8 12.8542n 1.8 12.8582n 2 12.875n 2 12.879n 1.8 12.8958n 1.8 12.8998n 1.8 12.9167n 1.8 12.9207n 2 12.9375n 2 12.9415n 1.8 12.9583n 1.8 12.9623n 1.8 12.9792n 1.8 12.9832n 1.8 13n 1.8 13.004n 1.8 13.0208n 1.8 13.0248n 1.8 13.0417n 1.8 13.0457n 2 13.0625n 2 13.0665n 1.8 13.0833n 1.8 13.0873n 1.8 13.1042n 1.8 13.1082n 1.8 13.125n 1.8 13.129n 2 13.1458n 2 13.1498n 1.8 13.1667n 1.8 13.1707n 2 13.1875n 2 13.1915n 2 13.2083n 2 13.2123n 2 13.2292n 2 13.2332n 2 13.25n 2 13.254n 1.8 13.2708n 1.8 13.2748n 1.8 13.2917n 1.8 13.2957n 2 13.3125n 2 13.3165n 2 13.3333n 2 13.3373n 2 13.3542n 2 13.3582n 2 13.375n 2 13.379n 2 13.3958n 2 13.3998n 1.8 13.4167n 1.8 13.4207n 1.8 13.4375n 1.8 13.4415n 1.8 13.4583n 1.8 13.4623n 2 13.4792n 2 13.4832n 2 13.5n 2 13.504n 2 13.5208n 2 13.5248n 1.8 13.5417n 1.8 13.5457n 1.8 13.5625n 1.8 13.5665n 1.8 13.5833n 1.8 13.5873n 2 13.6042n 2 13.6082n 1.8 13.625n 1.8 13.629n 1.8 13.6458n 1.8 13.6498n 2 13.6667n 2 13.6707n 1.8 13.6875n 1.8 13.6915n 2 13.7083n 2 13.7123n 2 13.7292n 2 13.7332n 1.8 13.75n 1.8 13.754n 2 13.7708n 2 13.7748n 1.8 13.7917n 1.8 13.7957n 2 13.8125n 2 13.8165n 1.8 13.8333n 1.8 13.8373n 1.8 13.8542n 1.8 13.8582n 1.8 13.875n 1.8 13.879n 2 13.8958n 2 13.8998n 1.8 13.9167n 1.8 13.9207n 1.8 13.9375n 1.8 13.9415n 2 13.9583n 2 13.9623n 2 13.9792n 2 13.9832n 1.8 14n 1.8 14.004n 1.8 14.0208n 1.8 14.0248n 2 14.0417n 2 14.0457n 2 14.0625n 2 14.0665n 2 14.0833n 2 14.0873n 1.8 14.1042n 1.8 14.1082n 2 14.125n 2 14.129n 2 14.1458n 2 14.1498n 2)
Vsmsbn smsbn 0 PWL(0 1.8 10n 1.8 10.004n 1.8 10.0208n 1.8 10.0248n 2 10.0417n 2 10.0457n 1.8 10.0625n 1.8 10.0665n 2 10.0833n 2 10.0873n 2 10.1042n 2 10.1082n 2 10.125n 2 10.129n 1.8 10.1458n 1.8 10.1498n 2 10.1667n 2 10.1707n 2 10.1875n 2 10.1915n 2 10.2083n 2 10.2123n 2 10.2292n 2 10.2332n 1.8 10.25n 1.8 10.254n 1.8 10.2708n 1.8 10.2748n 2 10.2917n 2 10.2957n 2 10.3125n 2 10.3165n 2 10.3333n 2 10.3373n 1.8 10.3542n 1.8 10.3582n 2 10.375n 2 10.379n 2 10.3958n 2 10.3998n 2 10.4167n 2 10.4207n 2 10.4375n 2 10.4415n 1.8 10.4583n 1.8 10.4623n 2 10.4792n 2 10.4832n 2 10.5n 2 10.504n 2 10.5208n 2 10.5248n 2 10.5417n 2 10.5457n 1.8 10.5625n 1.8 10.5665n 1.8 10.5833n 1.8 10.5873n 2 10.6042n 2 10.6082n 2 10.625n 2 10.629n 1.8 10.6458n 1.8 10.6498n 2 10.6667n 2 10.6707n 2 10.6875n 2 10.6915n 2 10.7083n 2 10.7123n 1.8 10.7292n 1.8 10.7332n 2 10.75n 2 10.754n 2 10.7708n 2 10.7748n 2 10.7917n 2 10.7957n 2 10.8125n 2 10.8165n 1.8 10.8333n 1.8 10.8373n 1.8 10.8542n 1.8 10.8582n 1.8 10.875n 1.8 10.879n 1.8 10.8958n 1.8 10.8998n 1.8 10.9167n 1.8 10.9207n 1.8 10.9375n 1.8 10.9415n 1.8 10.9583n 1.8 10.9623n 2 10.9792n 2 10.9832n 2 11n 2 11.004n 2 11.0208n 2 11.0248n 2 11.0417n 2 11.0457n 1.8 11.0625n 1.8 11.0665n 1.8 11.0833n 1.8 11.0873n 1.8 11.1042n 1.8 11.1082n 1.8 11.125n 1.8 11.129n 1.8 11.1458n 1.8 11.1498n 2 11.1667n 2 11.1707n 2 11.1875n 2 11.1915n 1.8 11.2083n 1.8 11.2123n 2 11.2292n 2 11.2332n 1.8 11.25n 1.8 11.254n 2 11.2708n 2 11.2748n 1.8 11.2917n 1.8 11.2957n 1.8 11.3125n 1.8 11.3165n 2 11.3333n 2 11.3373n 2 11.3542n 2 11.3582n 1.8 11.375n 1.8 11.379n 1.8 11.3958n 1.8 11.3998n 1.8 11.4167n 1.8 11.4207n 1.8 11.4375n 1.8 11.4415n 1.8 11.4583n 1.8 11.4623n 2 11.4792n 2 11.4832n 2 11.5n 2 11.504n 1.8 11.5208n 1.8 11.5248n 1.8 11.5417n 1.8 11.5457n 2 11.5625n 2 11.5665n 2 11.5833n 2 11.5873n 1.8 11.6042n 1.8 11.6082n 1.8 11.625n 1.8 11.629n 1.8 11.6458n 1.8 11.6498n 1.8 11.6667n 1.8 11.6707n 1.8 11.6875n 1.8 11.6915n 2 11.7083n 2 11.7123n 1.8 11.7292n 1.8 11.7332n 1.8 11.75n 1.8 11.754n 2 11.7708n 2 11.7748n 2 11.7917n 2 11.7957n 1.8 11.8125n 1.8 11.8165n 2 11.8333n 2 11.8373n 2 11.8542n 2 11.8582n 1.8 11.875n 1.8 11.879n 2 11.8958n 2 11.8998n 2 11.9167n 2 11.9207n 1.8 11.9375n 1.8 11.9415n 1.8 11.9583n 1.8 11.9623n 1.8 11.9792n 1.8 11.9832n 2 12n 2 12.004n 2 12.0208n 2 12.0248n 1.8 12.0417n 1.8 12.0457n 1.8 12.0625n 1.8 12.0665n 1.8 12.0833n 1.8 12.0873n 2 12.1042n 2 12.1082n 1.8 12.125n 1.8 12.129n 1.8 12.1458n 1.8 12.1498n 1.8 12.1667n 1.8 12.1707n 1.8 12.1875n 1.8 12.1915n 1.8 12.2083n 1.8 12.2123n 2 12.2292n 2 12.2332n 2 12.25n 2 12.254n 2 12.2708n 2 12.2748n 2 12.2917n 2 12.2957n 2 12.3125n 2 12.3165n 2 12.3333n 2 12.3373n 2 12.3542n 2 12.3582n 2 12.375n 2 12.379n 1.8 12.3958n 1.8 12.3998n 2 12.4167n 2 12.4207n 1.8 12.4375n 1.8 12.4415n 1.8 12.4583n 1.8 12.4623n 2 12.4792n 2 12.4832n 2 12.5n 2 12.504n 1.8 12.5208n 1.8 12.5248n 1.8 12.5417n 1.8 12.5457n 1.8 12.5625n 1.8 12.5665n 2 12.5833n 2 12.5873n 2 12.6042n 2 12.6082n 1.8 12.625n 1.8 12.629n 1.8 12.6458n 1.8 12.6498n 1.8 12.6667n 1.8 12.6707n 1.8 12.6875n 1.8 12.6915n 1.8 12.7083n 1.8 12.7123n 2 12.7292n 2 12.7332n 1.8 12.75n 1.8 12.754n 1.8 12.7708n 1.8 12.7748n 2 12.7917n 2 12.7957n 2 12.8125n 2 12.8165n 2 12.8333n 2 12.8373n 2 12.8542n 2 12.8582n 1.8 12.875n 1.8 12.879n 2 12.8958n 2 12.8998n 2 12.9167n 2 12.9207n 1.8 12.9375n 1.8 12.9415n 2 12.9583n 2 12.9623n 2 12.9792n 2 12.9832n 2 13n 2 13.004n 2 13.0208n 2 13.0248n 2 13.0417n 2 13.0457n 1.8 13.0625n 1.8 13.0665n 2 13.0833n 2 13.0873n 2 13.1042n 2 13.1082n 2 13.125n 2 13.129n 1.8 13.1458n 1.8 13.1498n 2 13.1667n 2 13.1707n 1.8 13.1875n 1.8 13.1915n 1.8 13.2083n 1.8 13.2123n 1.8 13.2292n 1.8 13.2332n 1.8 13.25n 1.8 13.254n 2 13.2708n 2 13.2748n 2 13.2917n 2 13.2957n 1.8 13.3125n 1.8 13.3165n 1.8 13.3333n 1.8 13.3373n 1.8 13.3542n 1.8 13.3582n 1.8 13.375n 1.8 13.379n 1.8 13.3958n 1.8 13.3998n 2 13.4167n 2 13.4207n 2 13.4375n 2 13.4415n 2 13.4583n 2 13.4623n 1.8 13.4792n 1.8 13.4832n 1.8 13.5n 1.8 13.504n 1.8 13.5208n 1.8 13.5248n 2 13.5417n 2 13.5457n 2 13.5625n 2 13.5665n 2 13.5833n 2 13.5873n 1.8 13.6042n 1.8 13.6082n 2 13.625n 2 13.629n 2 13.6458n 2 13.6498n 1.8 13.6667n 1.8 13.6707n 2 13.6875n 2 13.6915n 1.8 13.7083n 1.8 13.7123n 1.8 13.7292n 1.8 13.7332n 2 13.75n 2 13.754n 1.8 13.7708n 1.8 13.7748n 2 13.7917n 2 13.7957n 1.8 13.8125n 1.8 13.8165n 2 13.8333n 2 13.8373n 2 13.8542n 2 13.8582n 2 13.875n 2 13.879n 1.8 13.8958n 1.8 13.8998n 2 13.9167n 2 13.9207n 2 13.9375n 2 13.9415n 1.8 13.9583n 1.8 13.9623n 1.8 13.9792n 1.8 13.9832n 2 14n 2 14.004n 2 14.0208n 2 14.0248n 1.8 14.0417n 1.8 14.0457n 1.8 14.0625n 1.8 14.0665n 1.8 14.0833n 1.8 14.0873n 2 14.1042n 2 14.1082n 1.8 14.125n 1.8 14.129n 1.8 14.1458n 1.8 14.1498n 1.8)
Rsmsbp smsbp msbp 50
Rsmsbn smsbn msbn 50
Vslsbp slsbp 0 PWL(0 2 10n 2 10.004n 2 10.0208n 2 10.0248n 1.8 10.0417n 1.8 10.0457n 1.8 10.0625n 1.8 10.0665n 1.8 10.0833n 1.8 10.0873n 1.8 10.1042n 1.8 10.1082n 2 10.125n 2 10.129n 1.8 10.1458n 1.8 10.1498n 2 10.1667n 2 10.1707n 1.8 10.1875n 1.8 10.1915n 2 10.2083n 2 10.2123n 1.8 10.2292n 1.8 10.2332n 2 10.25n 2 10.254n 2 10.2708n 2 10.2748n 1.8 10.2917n 1.8 10.2957n 1.8 10.3125n 1.8 10.3165n 2 10.3333n 2 10.3373n 1.8 10.3542n 1.8 10.3582n 2 10.375n 2 10.379n 1.8 10.3958n 1.8 10.3998n 2 10.4167n 2 10.4207n 2 10.4375n 2 10.4415n 1.8 10.4583n 1.8 10.4623n 2 10.4792n 2 10.4832n 2 10.5n 2 10.504n 2 10.5208n 2 10.5248n 1.8 10.5417n 1.8 10.5457n 1.8 10.5625n 1.8 10.5665n 1.8 10.5833n 1.8 10.5873n 1.8 10.6042n 1.8 10.6082n 1.8 10.625n 1.8 10.629n 1.8 10.6458n 1.8 10.6498n 2 10.6667n 2 10.6707n 1.8 10.6875n 1.8 10.6915n 2 10.7083n 2 10.7123n 2 10.7292n 2 10.7332n 1.8 10.75n 1.8 10.754n 1.8 10.7708n 1.8 10.7748n 1.8 10.7917n 1.8 10.7957n 1.8 10.8125n 1.8 10.8165n 1.8 10.8333n 1.8 10.8373n 1.8 10.8542n 1.8 10.8582n 2 10.875n 2 10.879n 1.8 10.8958n 1.8 10.8998n 1.8 10.9167n 1.8 10.9207n 1.8 10.9375n 1.8 10.9415n 2 10.9583n 2 10.9623n 1.8 10.9792n 1.8 10.9832n 2 11n 2 11.004n 1.8 11.0208n 1.8 11.0248n 2 11.0417n 2 11.0457n 2 11.0625n 2 11.0665n 2 11.0833n 2 11.0873n 1.8 11.1042n 1.8 11.1082n 1.8 11.125n 1.8 11.129n 2 11.1458n 2 11.1498n 2 11.1667n 2 11.1707n 2 11.1875n 2 11.1915n 1.8 11.2083n 1.8 11.2123n 1.8 11.2292n 1.8 11.2332n 1.8 11.25n 1.8 11.254n 2 11.2708n 2 11.2748n 1.8 11.2917n 1.8 11.2957n 1.8 11.3125n 1.8 11.3165n 1.8 11.3333n 1.8 11.3373n 1.8 11.3542n 1.8 11.3582n 1.8 11.375n 1.8 11.379n 2 11.3958n 2 11.3998n 1.8 11.4167n 1.8 11.4207n 1.8 11.4375n 1.8 11.4415n 2 11.4583n 2 11.4623n 2 11.4792n 2 11.4832n 1.8 11.5n 1.8 11.504n 1.8 11.5208n 1.8 11.5248n 1.8 11.5417n 1.8 11.5457n 1.8 11.5625n 1.8 11.5665n 2 11.5833n 2 11.5873n 1.8 11.6042n 1.8 11.6082n 1.8 11.625n 1.8 11.629n 2 11.6458n 2 11.6498n 1.8 11.6667n 1.8 11.6707n 1.8 11.6875n 1.8 11.6915n 2 11.7083n 2 11.7123n 2 11.7292n 2 11.7332n 1.8 11.75n 1.8 11.754n 2 11.7708n 2 11.7748n 2 11.7917n 2 11.7957n 2 11.8125n 2 11.8165n 1.8 11.8333n 1.8 11.8373n 2 11.8542n 2 11.8582n 1.8 11.875n 1.8 11.879n 2 11.8958n 2 11.8998n 1.8 11.9167n 1.8 11.9207n 2 11.9375n 2 11.9415n 1.8 11.9583n 1.8 11.9623n 2 11.9792n 2 11.9832n 2 12n 2 12.004n 2 12.0208n 2 12.0248n 1.8 12.0417n 1.8 12.0457n 1.8 12.0625n 1.8 12.0665n 2 12.0833n 2 12.0873n 1.8 12.1042n 1.8 12.1082n 1.8 12.125n 1.8 12.129n 2 12.1458n 2 12.1498n 1.8 12.1667n 1.8 12.1707n 1.8 12.1875n 1.8 12.1915n 2 12.2083n 2 12.2123n 1.8 12.2292n 1.8 12.2332n 2 12.25n 2 12.254n 1.8 12.2708n 1.8 12.2748n 2 12.2917n 2 12.2957n 1.8 12.3125n 1.8 12.3165n 1.8 12.3333n 1.8 12.3373n 2 12.3542n 2 12.3582n 2 12.375n 2 12.379n 1.8 12.3958n 1.8 12.3998n 1.8 12.4167n 1.8 12.4207n 1.8 12.4375n 1.8 12.4415n 2 12.4583n 2 12.4623n 2 12.4792n 2 12.4832n 2 12.5n 2 12.504n 2 12.5208n 2 12.5248n 1.8 12.5417n 1.8 12.5457n 2 12.5625n 2 12.5665n 2 12.5833n 2 12.5873n 1.8 12.6042n 1.8 12.6082n 2 12.625n 2 12.629n 1.8 12.6458n 1.8 12.6498n 2 12.6667n 2 12.6707n 2 12.6875n 2 12.6915n 2 12.7083n 2 12.7123n 1.8 12.7292n 1.8 12.7332n 2 12.75n 2 12.754n 2 12.7708n 2 12.7748n 2 12.7917n 2 12.7957n 1.8 12.8125n 1.8 12.8165n 1.8 12.8333n 1.8 12.8373n 1.8 12.8542n 1.8 12.8582n 1.8 12.875n 1.8 12.879n 1.8 12.8958n 1.8 12.8998n 2 12.9167n 2 12.9207n 2 12.9375n 2 12.9415n 1.8 12.9583n 1.8 12.9623n 1.8 12.9792n 1.8 12.9832n 2 13n 2 13.004n 1.8 13.0208n 1.8 13.0248n 2 13.0417n 2 13.0457n 2 13.0625n 2 13.0665n 2 13.0833n 2 13.0873n 1.8 13.1042n 1.8 13.1082n 2 13.125n 2 13.129n 2 13.1458n 2 13.1498n 1.8 13.1667n 1.8 13.1707n 2 13.1875n 2 13.1915n 1.8 13.2083n 1.8 13.2123n 1.8 13.2292n 1.8 13.2332n 2 13.25n 2 13.254n 1.8 13.2708n 1.8 13.2748n 2 13.2917n 2 13.2957n 1.8 13.3125n 1.8 13.3165n 1.8 13.3333n 1.8 13.3373n 2 13.3542n 2 13.3582n 1.8 13.375n 1.8 13.379n 1.8 13.3958n 1.8 13.3998n 1.8 13.4167n 1.8 13.4207n 2 13.4375n 2 13.4415n 1.8 13.4583n 1.8 13.4623n 2 13.4792n 2 13.4832n 1.8 13.5n 1.8 13.504n 2 13.5208n 2 13.5248n 2 13.5417n 2 13.5457n 2 13.5625n 2 13.5665n 1.8 13.5833n 1.8 13.5873n 1.8 13.6042n 1.8 13.6082n 1.8 13.625n 1.8 13.629n 1.8 13.6458n 1.8 13.6498n 1.8 13.6667n 1.8 13.6707n 2 13.6875n 2 13.6915n 1.8 13.7083n 1.8 13.7123n 1.8 13.7292n 1.8 13.7332n 1.8 13.75n 1.8 13.754n 2 13.7708n 2 13.7748n 2 13.7917n 2 13.7957n 1.8 13.8125n 1.8 13.8165n 2 13.8333n 2 13.8373n 2 13.8542n 2 13.8582n 1.8 13.875n 1.8 13.879n 2 13.8958n 2 13.8998n 2 13.9167n 2 13.9207n 1.8 13.9375n 1.8 13.9415n 2 13.9583n 2 13.9623n 1.8 13.9792n 1.8 13.9832n 1.8 14n 1.8 14.004n 1.8 14.0208n 1.8 14.0248n 1.8 14.0417n 1.8 14.0457n 2 14.0625n 2 14.0665n 1.8 14.0833n 1.8 14.0873n 2 14.1042n 2 14.1082n 1.8 14.125n 1.8 14.129n 2 14.1458n 2 14.1498n 2)
Vslsbn slsbn 0 PWL(0 1.8 10n 1.8 10.004n 1.8 10.0208n 1.8 10.0248n 2 10.0417n 2 10.0457n 2 10.0625n 2 10.0665n 2 10.0833n 2 10.0873n 2 10.1042n 2 10.1082n 1.8 10.125n 1.8 10.129n 2 10.1458n 2 10.1498n 1.8 10.1667n 1.8 10.1707n 2 10.1875n 2 10.1915n 1.8 10.2083n 1.8 10.2123n 2 10.2292n 2 10.2332n 1.8 10.25n 1.8 10.254n 1.8 10.2708n 1.8 10.2748n 2 10.2917n 2 10.2957n 2 10.3125n 2 10.3165n 1.8 10.3333n 1.8 10.3373n 2 10.3542n 2 10.3582n 1.8 10.375n 1.8 10.379n 2 10.3958n 2 10.3998n 1.8 10.4167n 1.8 10.4207n 1.8 10.4375n 1.8 10.4415n 2 10.4583n 2 10.4623n 1.8 10.4792n 1.8 10.4832n 1.8 10.5n 1.8 10.504n 1.8 10.5208n 1.8 10.5248n 2 10.5417n 2 10.5457n 2 10.5625n 2 10.5665n 2 10.5833n 2 10.5873n 2 10.6042n 2 10.6082n 2 10.625n 2 10.629n 2 10.6458n 2 10.6498n 1.8 10.6667n 1.8 10.6707n 2 10.6875n 2 10.6915n 1.8 10.7083n 1.8 10.7123n 1.8 10.7292n 1.8 10.7332n 2 10.75n 2 10.754n 2 10.7708n 2 10.7748n 2 10.7917n 2 10.7957n 2 10.8125n 2 10.8165n 2 10.8333n 2 10.8373n 2 10.8542n 2 10.8582n 1.8 10.875n 1.8 10.879n 2 10.8958n 2 10.8998n 2 10.9167n 2 10.9207n 2 10.9375n 2 10.9415n 1.8 10.9583n 1.8 10.9623n 2 10.9792n 2 10.9832n 1.8 11n 1.8 11.004n 2 11.0208n 2 11.0248n 1.8 11.0417n 1.8 11.0457n 1.8 11.0625n 1.8 11.0665n 1.8 11.0833n 1.8 11.0873n 2 11.1042n 2 11.1082n 2 11.125n 2 11.129n 1.8 11.1458n 1.8 11.1498n 1.8 11.1667n 1.8 11.1707n 1.8 11.1875n 1.8 11.1915n 2 11.2083n 2 11.2123n 2 11.2292n 2 11.2332n 2 11.25n 2 11.254n 1.8 11.2708n 1.8 11.2748n 2 11.2917n 2 11.2957n 2 11.3125n 2 11.3165n 2 11.3333n 2 11.3373n 2 11.3542n 2 11.3582n 2 11.375n 2 11.379n 1.8 11.3958n 1.8 11.3998n 2 11.4167n 2 11.4207n 2 11.4375n 2 11.4415n 1.8 11.4583n 1.8 11.4623n 1.8 11.4792n 1.8 11.4832n 2 11.5n 2 11.504n 2 11.5208n 2 11.5248n 2 11.5417n 2 11.5457n 2 11.5625n 2 11.5665n 1.8 11.5833n 1.8 11.5873n 2 11.6042n 2 11.6082n 2 11.625n 2 11.629n 1.8 11.6458n 1.8 11.6498n 2 11.6667n 2 11.6707n 2 11.6875n 2 11.6915n 1.8 11.7083n 1.8 11.7123n 1.8 11.7292n 1.8 11.7332n 2 11.75n 2 11.754n 1.8 11.7708n 1.8 11.7748n 1.8 11.7917n 1.8 11.7957n 1.8 11.8125n 1.8 11.8165n 2 11.8333n 2 11.8373n 1.8 11.8542n 1.8 11.8582n 2 11.875n 2 11.879n 1.8 11.8958n 1.8 11.8998n 2 11.9167n 2 11.9207n 1.8 11.9375n 1.8 11.9415n 2 11.9583n 2 11.9623n 1.8 11.9792n 1.8 11.9832n 1.8 12n 1.8 12.004n 1.8 12.0208n 1.8 12.0248n 2 12.0417n 2 12.0457n 2 12.0625n 2 12.0665n 1.8 12.0833n 1.8 12.0873n 2 12.1042n 2 12.1082n 2 12.125n 2 12.129n 1.8 12.1458n 1.8 12.1498n 2 12.1667n 2 12.1707n 2 12.1875n 2 12.1915n 1.8 12.2083n 1.8 12.2123n 2 12.2292n 2 12.2332n 1.8 12.25n 1.8 12.254n 2 12.2708n 2 12.2748n 1.8 12.2917n 1.8 12.2957n 2 12.3125n 2 12.3165n 2 12.3333n 2 12.3373n 1.8 12.3542n 1.8 12.3582n 1.8 12.375n 1.8 12.379n 2 12.3958n 2 12.3998n 2 12.4167n 2 12.4207n 2 12.4375n 2 12.4415n 1.8 12.4583n 1.8 12.4623n 1.8 12.4792n 1.8 12.4832n 1.8 12.5n 1.8 12.504n 1.8 12.5208n 1.8 12.5248n 2 12.5417n 2 12.5457n 1.8 12.5625n 1.8 12.5665n 1.8 12.5833n 1.8 12.5873n 2 12.6042n 2 12.6082n 1.8 12.625n 1.8 12.629n 2 12.6458n 2 12.6498n 1.8 12.6667n 1.8 12.6707n 1.8 12.6875n 1.8 12.6915n 1.8 12.7083n 1.8 12.7123n 2 12.7292n 2 12.7332n 1.8 12.75n 1.8 12.754n 1.8 12.7708n 1.8 12.7748n 1.8 12.7917n 1.8 12.7957n 2 12.8125n 2 12.8165n 2 12.8333n 2 12.8373n 2 12.8542n 2 12.8582n 2 12.875n 2 12.879n 2 12.8958n 2 12.8998n 1.8 12.9167n 1.8 12.9207n 1.8 12.9375n 1.8 12.9415n 2 12.9583n 2 12.9623n 2 12.9792n 2 12.9832n 1.8 13n 1.8 13.004n 2 13.0208n 2 13.0248n 1.8 13.0417n 1.8 13.0457n 1.8 13.0625n 1.8 13.0665n 1.8 13.0833n 1.8 13.0873n 2 13.1042n 2 13.1082n 1.8 13.125n 1.8 13.129n 1.8 13.1458n 1.8 13.1498n 2 13.1667n 2 13.1707n 1.8 13.1875n 1.8 13.1915n 2 13.2083n 2 13.2123n 2 13.2292n 2 13.2332n 1.8 13.25n 1.8 13.254n 2 13.2708n 2 13.2748n 1.8 13.2917n 1.8 13.2957n 2 13.3125n 2 13.3165n 2 13.3333n 2 13.3373n 1.8 13.3542n 1.8 13.3582n 2 13.375n 2 13.379n 2 13.3958n 2 13.3998n 2 13.4167n 2 13.4207n 1.8 13.4375n 1.8 13.4415n 2 13.4583n 2 13.4623n 1.8 13.4792n 1.8 13.4832n 2 13.5n 2 13.504n 1.8 13.5208n 1.8 13.5248n 1.8 13.5417n 1.8 13.5457n 1.8 13.5625n 1.8 13.5665n 2 13.5833n 2 13.5873n 2 13.6042n 2 13.6082n 2 13.625n 2 13.629n 2 13.6458n 2 13.6498n 2 13.6667n 2 13.6707n 1.8 13.6875n 1.8 13.6915n 2 13.7083n 2 13.7123n 2 13.7292n 2 13.7332n 2 13.75n 2 13.754n 1.8 13.7708n 1.8 13.7748n 1.8 13.7917n 1.8 13.7957n 2 13.8125n 2 13.8165n 1.8 13.8333n 1.8 13.8373n 1.8 13.8542n 1.8 13.8582n 2 13.875n 2 13.879n 1.8 13.8958n 1.8 13.8998n 1.8 13.9167n 1.8 13.9207n 2 13.9375n 2 13.9415n 1.8 13.9583n 1.8 13.9623n 2 13.9792n 2 13.9832n 2 14n 2 14.004n 2 14.0208n 2 14.0248n 2 14.0417n 2 14.0457n 1.8 14.0625n 1.8 14.0665n 2 14.0833n 2 14.0873n 1.8 14.1042n 1.8 14.1082n 2 14.125n 2 14.129n 1.8 14.1458n 1.8 14.1498n 1.8)
Rslsbp slsbp lsbp 50
Rslsbn slsbn lsbn 50
* post-layout adapter: pam4drv_pam4_lay -> pam4drv_pam4 schematic ports
.subckt pam4drv_pam4 lsbp lsbn msbp msbn outp outn vcc vcasc vcmb blsb bmsb
Xlay sub msbn lsbp vcmb lsbn msbp tmsb0 tmsb1 tlsb0 vcasc outp outn vcc pam4drv_pam4_lay
Gtlsb0 tlsb0 0 blsb 0 1m
Gtmsb0 tmsb0 0 bmsb 0 1m
Gtmsb1 tmsb1 0 bmsb 0 1m
Vsub sub 0 DC 0
.ends pam4drv_pam4
.include "../../../report/layout/f/dut_pam4_post.spice"
.lib "cornerRES.lib" res_typ
.lib "cornerCAP.lib" cap_typ

.lib "cornerHBT.lib" hbt_typ
.options gmin=1e-12 reltol=1e-3
.control
tran 0.000520833n 15.1667n uic
wrdata eye.csv v(outp)-v(outn)
.endc
.GLOBAL GND
.end
